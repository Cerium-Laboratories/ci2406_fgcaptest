** sch_path: /home/amedcalf/projects/ci2406_fgcaptest/xschem/fgcell_amp.sch
.subckt fgcell_amp vfg vctrl vinj row_en_6v0_b vsrc vtun VGND vout row_en_6v0 vb
*.PININFO vinj:I row_en_6v0_b:I vtun:I vctrl:I vsrc:I vb:I VGND:I vout:O vfg:B row_en_6v0:I
x1 vinj row_en_6v0_b vtun vctrl vsrc VGND vfg fgcell
x2 vfg net1 VGND vinj vb net1 diffamp_nmos
x3 net1 vout row_en_6v0 row_en_6v0_b vinj VGND tg5v0
.ends

* expanding   symbol:  fgcell.sym # of pins=7
** sym_path: /home/amedcalf/projects/ci2406_fgcaptest/xschem/fgcell.sym
** sch_path: /home/amedcalf/projects/ci2406_fgcaptest/xschem/fgcell.sch
.subckt fgcell vinj vinj_en_b vtun vctrl vsrc VGND vfg
*.PININFO vinj:I vinj_en_b:I vtun:I vctrl:I vsrc:I VGND:I vfg:O
XM1 vsrc vfg net1 vinj sky130_fd_pr__pfet_g5v0d10v5 L=0.5 W=1 nf=1 m=1
XM2 net1 vinj_en_b vinj vinj sky130_fd_pr__pfet_g5v0d10v5 L=0.5 W=1 nf=1 m=1
XC1 vfg vtun VGND sky130_fd_pr__cap_var_hvt W=1 L=0.5 m=1
XM3 vctrl vfg vctrl vctrl sky130_fd_pr__pfet_g5v0d10v5 L=0.5 W=1 nf=1 m=1
.ends

* expanding   symbol:  diffamp_nmos.sym # of pins=6
** sym_path: /home/amedcalf/projects/ci2406_fgcaptest/xschem/diffamp_nmos.sym
** sch_path: /home/amedcalf/projects/ci2406_fgcaptest/xschem/diffamp_nmos.sch
.subckt diffamp_nmos v1 v2 VSS VDD vb vout
*.PININFO v1:I v2:I vb:I vout:O VDD:I VSS:I
XM7 int2 int3 VDD VDD sky130_fd_pr__pfet_g5v0d10v5 L=1 W=1.5 nf=1 m=1
XM8 int2 int2 VSS VSS sky130_fd_pr__nfet_g5v0d10v5 L=1 W=1.5 nf=1 m=1
XM9 vout int2 VSS VSS sky130_fd_pr__nfet_g5v0d10v5 L=1 W=1.5 nf=1 m=1
XM1 int4 v1 int1 VSS sky130_fd_pr__nfet_g5v0d10v5 L=1 W=1.5 nf=1 m=1
XM2 int3 v2 int1 VSS sky130_fd_pr__nfet_g5v0d10v5 L=1 W=1.5 nf=1 m=1
XM6 int3 int3 VDD VDD sky130_fd_pr__pfet_g5v0d10v5 L=1 W=1.5 nf=1 m=1
XM5 vout int4 VDD VDD sky130_fd_pr__pfet_g5v0d10v5 L=1 W=1.5 nf=1 m=1
XM3a int1 vb int5 VSS sky130_fd_pr__nfet_g5v0d10v5 L=1 W=1.5 nf=1 m=1
XM3b int5 vb VSS VSS sky130_fd_pr__nfet_g5v0d10v5 L=1 W=1.5 nf=1 m=1
XM4 int4 int4 VDD VDD sky130_fd_pr__pfet_g5v0d10v5 L=1 W=1.5 nf=1 m=1
.ends

* expanding   symbol:  tg5v0.sym # of pins=6
** sym_path: /home/amedcalf/projects/ci2406_fgcaptest/xschem/tg5v0.sym
** sch_path: /home/amedcalf/projects/ci2406_fgcaptest/xschem/tg5v0.sch
.subckt tg5v0 vin vout en en_b vdd vss
*.PININFO vin:I vout:O en:I en_b:I vdd:I vss:I
XM1 vout en vin vss sky130_fd_pr__nfet_g5v0d10v5 L=0.5 W=4 nf=8 m=1
XM2 vout en_b vin vdd sky130_fd_pr__pfet_g5v0d10v5 L=0.5 W=4 nf=8 m=1
.ends

.end
