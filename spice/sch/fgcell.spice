** sch_path: /home/amedcalf/projects/ci2406_fgcaptest/xschem/fgcell.sch
.subckt fgcell vinj vinj_en_b vtun vctrl vsrc VGND vfg
*.PININFO vinj:I vinj_en_b:I vtun:I vctrl:I vsrc:I VGND:I vfg:O
XM1 vsrc vfg net1 vinj sky130_fd_pr__pfet_g5v0d10v5 L=0.5 W=1 nf=1 m=1
XM2 net1 vinj_en_b vinj vinj sky130_fd_pr__pfet_g5v0d10v5 L=0.5 W=1 nf=1 m=1
XC1 vfg vtun VGND sky130_fd_pr__cap_var_hvt W=1 L=0.5 m=1
XM3 vctrl vfg vctrl vctrl sky130_fd_pr__pfet_g5v0d10v5 L=0.5 W=1 nf=1 m=1
.ends
.end
